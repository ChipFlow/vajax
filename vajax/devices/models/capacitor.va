// VAJAX capacitor model
// SPDX-License-Identifier: Apache-2.0
// Copyright 2026 ChipFlow
//
// Simple two-terminal capacitor with charge-based formulation.

`include "constants.vams"
`include "disciplines.vams"

module capacitor(A, B);
    inout A, B;
    electrical A, B;

    branch (A, B) br;

    (* desc = "Capacitance", type = "instance", units = "F" *)
    parameter real c = 1e-12 from (0:inf);

    real q;

    analog begin
        q = c * V(br);
        I(br) <+ ddt(q);
    end
endmodule
