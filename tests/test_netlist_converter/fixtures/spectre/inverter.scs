// Simple CMOS inverter in Spectre format
// Based on common Spectre netlist patterns

simulator lang=spectre

// Model definitions
model nch nmos type=n \
    toxe=1.8e-9 toxp=1.5e-9 \
    vth0=0.4 k1=0.5 k2=0.0 \
    dvt0=0.0 dvt1=0.0

model pch pmos type=p \
    toxe=1.8e-9 toxp=1.5e-9 \
    vth0=-0.4 k1=0.5 k2=0.0 \
    dvt0=0.0 dvt1=0.0

// Inverter subcircuit
subckt inv (in out vdd vss) parameters wp=1u wn=500n l=100n
    Mp (out in vdd vdd) pch w=wp l=l
    Mn (out in vss vss) nch w=wn l=l
ends inv

// Buffer subcircuit (two inverters)
subckt buffer (in out vdd vss) parameters wp=1u wn=500n l=100n
    I1 (in mid vdd vss) inv wp=wp wn=wn l=l
    I2 (mid out vdd vss) inv wp=wp wn=wn l=l
ends buffer

// Test instantiation
I0 (input output VDD GND) buffer wp=2u wn=1u l=100n

// Voltage sources
V0 (VDD 0) vsource dc=1.8 type=dc
V1 (input 0) vsource dc=0 type=pulse val0=0 val1=1.8 period=1n rise=100p fall=100p
