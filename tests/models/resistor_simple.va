`include "constants.vams"
`include "disciplines.vams"

// Simple resistor model without noise (for testing)
module resistor_simple(A,B);
    inout A, B;
    electrical A, B;

    branch (A,B) br;

    (*desc= "Resistance", type="instance", units = "Ohm"*) parameter real r = 1 from [0:inf];
    (*desc= "Current", units ="A" *) real i;

    analog begin
        I(br) <+ V(br)/r;
        i = V(br) / r;
    end
endmodule
