`include "constants.vams"
`include "disciplines.vams"

module resistor(A,B);
	inout A, B;
	electrical A, B;

	branch (A,B) br;

	(*desc= "Resistance", type="instance", units = "Ohm"*) parameter real r = 1 from [0:inf];
    (*desc= "Noise switch", type="model", units = ""*)  parameter integer has_noise = 1;
	(*desc= "Current", units ="A" *) real i;

	analog begin
        I(br) <+ V(br)/r;
        i = V(br) / r;
        if (has_noise)
            I(br) <+ white_noise(4*`P_K*$temperature/r, "thermal");
	end
endmodule
